* install check: 5V across two equal resistors
V1 in 0 DC 5
R1 in out 10k
R2 out 0 10k
.control
op
print v(out)
quit
.endc
.end
